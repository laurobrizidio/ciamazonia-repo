** sch_path: /home/designer/shared/SRAM.sch
**.subckt SRAM
VBL VBL GND PULSE(0 5 2m 1u 1u 5m 10m)
VWL VWL GND PULSE(0 5 0m 1u 1u 3m 6m)
VDD VDD GND 5
VBLB VBLB GND PULSE(5 0 2m 1u 1u 6m 10m)
XM5 Q QB VDD VDD sg13_lv_pmos w=0.15u l=0.13u ng=1 m=1
XM9 Q QB GND GND sg13_lv_nmos w=0.15u l=0.13u ng=1 m=1
XM8 QB Q VDD VDD sg13_lv_pmos w=0.15u l=0.13u ng=1 m=1
XM1 GND Q QB GND sg13_lv_nmos w=0.15u l=0.13u ng=1 m=1
XM2 Q VWL VBL GND sg13_lv_nmos w=0.15u l=0.13u ng=1 m=1
XM3 QB VWL VBLB GND sg13_lv_nmos w=0.15u l=0.13u ng=1 m=1
**** begin user architecture code

.lib cornerMOSlv.lib mos_tt

.tran 0.05m 20m
.save all

**** end user architecture code
**.ends
.GLOBAL VDD
.GLOBAL GND
.end
